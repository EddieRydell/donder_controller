`define OUTPUT_COUNT 30
`define PIN_OUTPUT_COUNT 30
`define PIXELS_PER_OUTPUT 1024
`define DEFAULT_ACTIVE_OUTPUT_COUNT 30
`define DEFAULT_STRAND_PIXEL_COUNT 113
`define DEFAULT_OUTPUT_INVERT_MASK 1073741823
`define WS281X_BIT_RATE 800000
`define FRAME_BANKS 2
`define CONTROL_BASEADDR 32'h43c00000
`define CONTROL_RANGE_BYTES 4096
`define FRAME_RAM_BASEADDR 32'h43c80000
`define FRAME_WORDS_PER_BANK (`OUTPUT_COUNT * `PIXELS_PER_OUTPUT)
`define FRAME_WORDS (`FRAME_BANKS * `FRAME_WORDS_PER_BANK)
`define FRAME_RAM_RANGE_BYTES 262144
`define E131_PORT 5568
`define E131_FIRST_UNIVERSE 1
`define E131_SLOTS_PER_UNIVERSE 510
`define E131_BLACKOUT_TIMEOUT_MS 5000
`define E131_ACCEPT_PREVIEW 0
`define E131_DEFAULT_SYNC_ADDRESS 63999
`define BOARD_IP0 192
`define BOARD_IP1 168
`define BOARD_IP2 7
`define BOARD_IP3 2
`define HOST_IP0 192
`define HOST_IP1 168
`define HOST_IP2 7
`define HOST_IP3 1
`define NETMASK_IP0 255
`define NETMASK_IP1 255
`define NETMASK_IP2 255
`define NETMASK_IP3 0
`define GATEWAY_IP0 0
`define GATEWAY_IP1 0
`define GATEWAY_IP2 0
`define GATEWAY_IP3 0
`define MAC0 2
`define MAC1 10
`define MAC2 53
`define MAC3 7
`define MAC4 0
`define MAC5 2
`define UART_BAUD 115200
`define JTAG_HW_SERVER_PORT 3121
`define RX_PACKET_RING_DEPTH 1024
`define E131_MAX_PACKET_BYTES 638
`define LWIP_MEM_SIZE 786432
`define LWIP_PBUF_POOL_SIZE 1536
`define LWIP_RX_DESCRIPTORS 256

addrmap pl_control #(
    longint unsigned P_OUTPUT_COUNT = `OUTPUT_COUNT,
    longint unsigned P_PIN_OUTPUT_COUNT = `PIN_OUTPUT_COUNT,
    longint unsigned P_PIXELS_PER_OUTPUT = `PIXELS_PER_OUTPUT,
    longint unsigned P_DEFAULT_ACTIVE_OUTPUT_COUNT = `DEFAULT_ACTIVE_OUTPUT_COUNT,
    longint unsigned P_DEFAULT_STRAND_PIXEL_COUNT = `DEFAULT_STRAND_PIXEL_COUNT,
    longint unsigned P_DEFAULT_OUTPUT_INVERT_MASK = `DEFAULT_OUTPUT_INVERT_MASK,
    longint unsigned P_WS281X_BIT_RATE = `WS281X_BIT_RATE,
    longint unsigned P_FRAME_BANKS = `FRAME_BANKS,
    longint unsigned P_CONTROL_RANGE_BYTES = `CONTROL_RANGE_BYTES,
    longint unsigned P_E131_PORT = `E131_PORT,
    longint unsigned P_E131_FIRST_UNIVERSE = `E131_FIRST_UNIVERSE,
    longint unsigned P_E131_SLOTS_PER_UNIVERSE = `E131_SLOTS_PER_UNIVERSE,
    longint unsigned P_E131_BLACKOUT_TIMEOUT_MS = `E131_BLACKOUT_TIMEOUT_MS,
    longint unsigned P_E131_ACCEPT_PREVIEW = `E131_ACCEPT_PREVIEW,
    longint unsigned P_E131_DEFAULT_SYNC_ADDRESS = `E131_DEFAULT_SYNC_ADDRESS,
    longint unsigned P_BOARD_IP0 = `BOARD_IP0,
    longint unsigned P_BOARD_IP1 = `BOARD_IP1,
    longint unsigned P_BOARD_IP2 = `BOARD_IP2,
    longint unsigned P_BOARD_IP3 = `BOARD_IP3,
    longint unsigned P_HOST_IP0 = `HOST_IP0,
    longint unsigned P_HOST_IP1 = `HOST_IP1,
    longint unsigned P_HOST_IP2 = `HOST_IP2,
    longint unsigned P_HOST_IP3 = `HOST_IP3,
    longint unsigned P_NETMASK_IP0 = `NETMASK_IP0,
    longint unsigned P_NETMASK_IP1 = `NETMASK_IP1,
    longint unsigned P_NETMASK_IP2 = `NETMASK_IP2,
    longint unsigned P_NETMASK_IP3 = `NETMASK_IP3,
    longint unsigned P_GATEWAY_IP0 = `GATEWAY_IP0,
    longint unsigned P_GATEWAY_IP1 = `GATEWAY_IP1,
    longint unsigned P_GATEWAY_IP2 = `GATEWAY_IP2,
    longint unsigned P_GATEWAY_IP3 = `GATEWAY_IP3,
    longint unsigned P_MAC0 = `MAC0,
    longint unsigned P_MAC1 = `MAC1,
    longint unsigned P_MAC2 = `MAC2,
    longint unsigned P_MAC3 = `MAC3,
    longint unsigned P_MAC4 = `MAC4,
    longint unsigned P_MAC5 = `MAC5,
    longint unsigned P_UART_BAUD = `UART_BAUD,
    longint unsigned P_JTAG_HW_SERVER_PORT = `JTAG_HW_SERVER_PORT,
    longint unsigned P_RX_PACKET_RING_DEPTH = `RX_PACKET_RING_DEPTH,
    longint unsigned P_E131_MAX_PACKET_BYTES = `E131_MAX_PACKET_BYTES,
    longint unsigned P_LWIP_MEM_SIZE = `LWIP_MEM_SIZE,
    longint unsigned P_LWIP_PBUF_POOL_SIZE = `LWIP_PBUF_POOL_SIZE,
    longint unsigned P_LWIP_RX_DESCRIPTORS = `LWIP_RX_DESCRIPTORS
) {
    name = "PL control register block";
    desc = "Local PS-to-PL control and status register block. Offsets are relative to the 4 KiB control aperture assigned by Vivado.";

    reg {
        name = "ID";
        desc = "Identity value. Must read 0x4546504c.";
        field { sw = r; hw = na; reset = 32'h4546504c; } value[31:0];
    } ID @ 12'h000;

    reg {
        name = "VERSION";
        desc = "Register contract version. Must read 0x00080000.";
        field { sw = r; hw = na; reset = 32'h00080000; } value[31:0];
    } VERSION @ 12'h004;

    reg {
        name = "CONTROL";
        desc = "Software control bits.";
        field { sw = rw; hw = r; reset = 1'b0; swmod = true; desc = "Write 1 to clear sticky status."; } clear_errors[1:1];
        field { sw = rw; hw = r; reset = 1'b0; } reserved[0:0];
    } CONTROL @ 12'h008;

    reg {
        name = "STATUS";
        desc = "PL status bits.";
        field { sw = r; hw = w; reset = 1'b1; desc = "Control block is ready."; } ready[0:0];
        field { sw = r; hw = w; reset = 1'b0; desc = "Last commit exceeded bank capacity."; } overflow[1:1];
        field { sw = r; hw = w; reset = 1'b0; desc = "WS281x consumer detected an error."; } consumer_error[2:2];
        field { sw = r; hw = w; reset = 1'b0; desc = "Last commit targeted a non-free bank."; } commit_rejected[3:3];
    } STATUS @ 12'h00c;

    reg {
        name = "PIN_OUT";
        desc = "Debug mirror of the first committed frame word.";
        field { sw = rw; hw = rw; reset = 32'h0; swmod = true; } value[31:0];
    } PIN_OUT @ 12'h010;

    reg {
        name = "COUNTER";
        desc = "Free-running PL clock counter.";
        field { sw = r; hw = w; reset = 32'h0; } value[31:0];
    } COUNTER @ 12'h014;

    reg {
        name = "FRAME_CAPACITY";
        desc = "PL frame storage capacity in 32-bit words. The frame store is intentionally fixed at two banks.";
        field { sw = r; hw = w; reset = P_OUTPUT_COUNT * P_PIXELS_PER_OUTPUT * P_FRAME_BANKS; } value[31:0];
    } FRAME_CAPACITY @ 12'h018;

    reg {
        name = "FRAME_COMMIT";
        desc = "Atomic frame commit. Bit 31 selects one of the fixed two frame banks; bits 30:0 are word count.";
        field { sw = w; hw = r; reset = 31'h0; swmod = true; } word_count[30:0];
        field { sw = w; hw = r; reset = 1'b0; swmod = true; } bank[31:31];
    } FRAME_COMMIT @ 12'h020;

    reg {
        name = "FRAME_COUNT";
        desc = "Accepted frame commit count.";
        field { sw = r; hw = w; reset = 32'h0; } value[31:0];
    } FRAME_COUNT @ 12'h024;

    reg {
        name = "COMMITTED_WORDS";
        desc = "Word count from the last accepted commit.";
        field { sw = r; hw = w; reset = 32'h0; } value[31:0];
    } COMMITTED_WORDS @ 12'h028;

    reg {
        name = "FIRST_FRAME_WORD";
        desc = "First word metadata staged by software and latched on commit.";
        field { sw = rw; hw = rw; reset = 32'h0; swmod = true; } value[31:0];
    } FIRST_FRAME_WORD @ 12'h02c;

    reg {
        name = "LAST_FRAME_WORD";
        desc = "Last word metadata staged by software and latched on commit.";
        field { sw = rw; hw = rw; reset = 32'h0; swmod = true; } value[31:0];
    } LAST_FRAME_WORD @ 12'h030;

    reg {
        name = "ERROR_COUNT";
        desc = "Protocol errors detected by PL.";
        field { sw = r; hw = w; reset = 32'h0; } value[31:0];
    } ERROR_COUNT @ 12'h034;

    reg {
        name = "FRAME_BANK_WORDS";
        desc = "Words per frame bank. The runtime contract always has two banks.";
        field { sw = r; hw = w; reset = P_OUTPUT_COUNT * P_PIXELS_PER_OUTPUT; } value[31:0];
    } FRAME_BANK_WORDS @ 12'h038;

    reg {
        name = "ACTIVE_BANK";
        desc = "Bank currently committed to PL/debug.";
        field { sw = r; hw = w; reset = 32'h0; } value[31:0];
    } ACTIVE_BANK @ 12'h03c;

    reg {
        name = "WRITE_BANK";
        desc = "Bank currently owned by PS writes.";
        field { sw = r; hw = w; reset = 32'h1; } value[31:0];
    } WRITE_BANK @ 12'h040;

    reg {
        name = "FRAME_SEQUENCE";
        desc = "Monotonic accepted-commit sequence.";
        field { sw = r; hw = w; reset = 32'h0; } value[31:0];
    } FRAME_SEQUENCE @ 12'h044;

    reg {
        name = "CONSUMER_CONTROL";
        desc = "WS281x consumer control.";
        field { sw = rw; hw = r; reset = 1'b0; } enable[0:0];
        field { sw = rw; hw = r; reset = 1'b0; swmod = true; } reset_fsm[1:1];
    } CONSUMER_CONTROL @ 12'h048;

    reg {
        name = "CONSUMER_STATUS";
        desc = "WS281x consumer status.";
        field { sw = r; hw = w; reset = 1'b0; } enabled[0:0];
        field { sw = r; hw = w; reset = 1'b0; } busy[1:1];
        field { sw = r; hw = w; reset = 1'b0; } reset_low[2:2];
        field { sw = r; hw = w; reset = 1'b0; } error[3:3];
    } CONSUMER_STATUS @ 12'h04c;

    reg {
        name = "CONSUMER_SEQUENCE";
        desc = "Last frame sequence fully consumed by WS281x serializer.";
        field { sw = r; hw = w; reset = 32'h0; } value[31:0];
    } CONSUMER_SEQUENCE @ 12'h050;

    reg {
        name = "CONSUMER_FRAME_COUNT";
        desc = "Completed WS281x frame transmissions.";
        field { sw = r; hw = w; reset = 32'h0; } value[31:0];
    } CONSUMER_FRAME_COUNT @ 12'h054;

    reg {
        name = "CONSUMER_ERROR_COUNT";
        desc = "Consumer-side protocol/read errors.";
        field { sw = r; hw = w; reset = 32'h0; } value[31:0];
    } CONSUMER_ERROR_COUNT @ 12'h058;

    reg {
        name = "WS281X_BIT_RATE";
        desc = "Configured serializer bit rate.";
        field { sw = r; hw = na; reset = P_WS281X_BIT_RATE; } value[31:0];
    } WS281X_BIT_RATE @ 12'h05c;

    reg {
        name = "WS281X_OUTPUT_COUNT";
        desc = "Configured parallel output count.";
        field { sw = r; hw = na; reset = P_OUTPUT_COUNT; } value[31:0];
    } WS281X_OUTPUT_COUNT @ 12'h060;

    reg {
        name = "WS281X_PIXELS_PER_OUTPUT";
        desc = "Configured pixels per output.";
        field { sw = r; hw = na; reset = P_PIXELS_PER_OUTPUT; } value[31:0];
    } WS281X_PIXELS_PER_OUTPUT @ 12'h064;

    reg {
        name = "CONSUMER_DEBUG";
        desc = "Packed FSM debug snapshot for JTAG bring-up.";
        field { sw = r; hw = w; reset = 32'h0; } value[31:0];
    } CONSUMER_DEBUG @ 12'h068;

    reg {
        name = "WRITE_BANK_VALID";
        desc = "One when WRITE_BANK is safe for PS writes.";
        field { sw = r; hw = w; reset = 1'b1; } value[0:0];
    } WRITE_BANK_VALID @ 12'h06c;

    reg {
        name = "BUSY_BANK";
        desc = "Bank currently being consumed, or 0xffffffff when idle.";
        field { sw = r; hw = w; reset = 32'hffffffff; } value[31:0];
    } BUSY_BANK @ 12'h070;

    reg {
        name = "FRAME_DROPPED";
        desc = "Frames intentionally dropped by software because no bank was free.";
        field { sw = r; hw = w; reset = 32'h0; } value[31:0];
    } FRAME_DROPPED @ 12'h074;

    reg {
        name = "FRAME_REJECTED";
        desc = "Frame commits rejected by hardware because the target bank was not free or valid.";
        field { sw = r; hw = w; reset = 32'h0; } value[31:0];
    } FRAME_REJECTED @ 12'h078;

    reg {
        name = "FRAME_DROP_NOTIFY";
        desc = "Software writes one to count an intentionally dropped frame.";
        field { sw = w; hw = r; reset = 1'b0; swmod = true; } value[0:0];
    } FRAME_DROP_NOTIFY @ 12'h07c;

    reg {
        name = "ACTIVE_OUTPUT_COUNT";
        desc = "Runtime active WS281x output count. Hardware clamps values above the synthesized output count.";
        field { sw = rw; hw = r; reset = P_DEFAULT_ACTIVE_OUTPUT_COUNT; swmod = true; } value[31:0];
    } ACTIVE_OUTPUT_COUNT @ 12'h080;

    reg {
        name = "STRAND_PIXEL_COUNT";
        desc = "Runtime pixel count for each WS281x output. Hardware clamps values above the synthesized pixels per output.";
        field { sw = rw; hw = r; reset = P_DEFAULT_STRAND_PIXEL_COUNT; swmod = true; } value[31:0];
    } STRAND_PIXEL_COUNT[P_OUTPUT_COUNT] @ 12'h084 += 4;

    reg {
        name = "CONFIG_STATUS";
        desc = "Runtime WS281x configuration status. config_invalid is sticky until CONTROL.clear_errors.";
        field { sw = r; hw = w; reset = 1'b0; desc = "A raw runtime config write exceeded a synthesized maximum."; } config_invalid[0:0];
        field { sw = r; hw = w; reset = 1'b0; desc = "Current active output count raw value is being clamped."; } active_count_clamped[1:1];
    } CONFIG_STATUS @ 12'h0fc;

    reg {
        name = "STRAND_LENGTH_CLAMPED";
        desc = "Runtime per-output length clamp status. Bit n is set when output n raw length exceeds the synthesized pixels per output.";
        field { sw = r; hw = w; reset = 32'h0; } value[31:0];
    } STRAND_LENGTH_CLAMPED[1] @ 12'h100 += 4;

    reg {
        name = "OUTPUT_INVERT_MASK";
        desc = "Runtime WS281x output inversion mask words. Bit n inverts physical output n after serialization.";
        field { sw = rw; hw = r; reset = P_DEFAULT_OUTPUT_INVERT_MASK; desc = "Output inversion mask word. Bits above the synthesized output count are ignored."; } value[31:0];
    } OUTPUT_INVERT_MASK[(P_OUTPUT_COUNT + 31) / 32] @ 12'h104 += 4;
};

addrmap dawn_pl {
    name = "Dawn PL system address map";
    desc = "Absolute PS-visible placement for the PL control block and frame RAM aperture.";

    pl_control #(
        .P_OUTPUT_COUNT(`OUTPUT_COUNT),
        .P_PIN_OUTPUT_COUNT(`PIN_OUTPUT_COUNT),
        .P_PIXELS_PER_OUTPUT(`PIXELS_PER_OUTPUT),
        .P_DEFAULT_ACTIVE_OUTPUT_COUNT(`DEFAULT_ACTIVE_OUTPUT_COUNT),
        .P_DEFAULT_STRAND_PIXEL_COUNT(`DEFAULT_STRAND_PIXEL_COUNT),
        .P_DEFAULT_OUTPUT_INVERT_MASK(`DEFAULT_OUTPUT_INVERT_MASK),
        .P_WS281X_BIT_RATE(`WS281X_BIT_RATE),
        .P_FRAME_BANKS(`FRAME_BANKS),
        .P_CONTROL_RANGE_BYTES(`CONTROL_RANGE_BYTES),
        .P_E131_PORT(`E131_PORT),
        .P_E131_FIRST_UNIVERSE(`E131_FIRST_UNIVERSE),
        .P_E131_SLOTS_PER_UNIVERSE(`E131_SLOTS_PER_UNIVERSE),
        .P_E131_BLACKOUT_TIMEOUT_MS(`E131_BLACKOUT_TIMEOUT_MS),
        .P_E131_ACCEPT_PREVIEW(`E131_ACCEPT_PREVIEW),
        .P_E131_DEFAULT_SYNC_ADDRESS(`E131_DEFAULT_SYNC_ADDRESS),
        .P_BOARD_IP0(`BOARD_IP0),
        .P_BOARD_IP1(`BOARD_IP1),
        .P_BOARD_IP2(`BOARD_IP2),
        .P_BOARD_IP3(`BOARD_IP3),
        .P_HOST_IP0(`HOST_IP0),
        .P_HOST_IP1(`HOST_IP1),
        .P_HOST_IP2(`HOST_IP2),
        .P_HOST_IP3(`HOST_IP3),
        .P_NETMASK_IP0(`NETMASK_IP0),
        .P_NETMASK_IP1(`NETMASK_IP1),
        .P_NETMASK_IP2(`NETMASK_IP2),
        .P_NETMASK_IP3(`NETMASK_IP3),
        .P_GATEWAY_IP0(`GATEWAY_IP0),
        .P_GATEWAY_IP1(`GATEWAY_IP1),
        .P_GATEWAY_IP2(`GATEWAY_IP2),
        .P_GATEWAY_IP3(`GATEWAY_IP3),
        .P_MAC0(`MAC0),
        .P_MAC1(`MAC1),
        .P_MAC2(`MAC2),
        .P_MAC3(`MAC3),
        .P_MAC4(`MAC4),
        .P_MAC5(`MAC5),
        .P_UART_BAUD(`UART_BAUD),
        .P_JTAG_HW_SERVER_PORT(`JTAG_HW_SERVER_PORT),
        .P_RX_PACKET_RING_DEPTH(`RX_PACKET_RING_DEPTH),
        .P_E131_MAX_PACKET_BYTES(`E131_MAX_PACKET_BYTES),
        .P_LWIP_MEM_SIZE(`LWIP_MEM_SIZE),
        .P_LWIP_PBUF_POOL_SIZE(`LWIP_PBUF_POOL_SIZE),
        .P_LWIP_RX_DESCRIPTORS(`LWIP_RX_DESCRIPTORS)
    ) control @ `CONTROL_BASEADDR;

    external mem {
        name = "PL frame RAM";
        desc = "PS-writable frame RAM aperture consumed by the WS281x controller.";
        mementries = `FRAME_RAM_RANGE_BYTES / 4;
        memwidth = 32;
    } frame_ram @ `FRAME_RAM_BASEADDR;
};
